* USB 5 V -> PTC -> BQ24074 power-path -> VSYS LDO (ngspice)
* First-spin power path. Not a substitute for measuring Korvo / SMT current.

.title pixel-snap-voice power path
Vusb n_vbus 0 DC 5
Rptc n_vbus n_in 0.3
* BQ24074-class: USB present, cell at 3.8 V. OUT is VSYS; BAT is the pouch only.
Vbat n_bat 0 DC 3.8
Rpath n_in n_sys 0.4
Rchg n_in n_bat 2.0
* MCU+codec record load ~160 mA from 3.3 V after LDO, fed from VSYS
Rldo n_sys n_3v3 0.4
Iload n_3v3 0 DC 0.16

.control
tran 10u 2m
print v(n_vbus) v(n_in) v(n_sys) v(n_bat) v(n_3v3)
echo power_path: ok if n_3v3 stays near 3.3-3.7 V with Vbat=3.8 and USB up
.endc
.end
